* NGSPICE file created from EG1022N_V2.ext - technology: gf180mcuC

.subckt EG1022N_V2 c b e s
X0 c b e s npn_00p54x16p00
**devattr s=346852,5955 d=11974822,19457
.ends
